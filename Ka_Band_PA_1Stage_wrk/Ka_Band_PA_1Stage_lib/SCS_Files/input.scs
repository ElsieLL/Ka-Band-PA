// Design: zl_Doherty_Transmitter/3CS_noRNW_Cal
simulator lang=spectre
global 0
include "/home/PDK/pdk_40nm_45nm_cmos_mixed_signal_rf_gp_1P10M_al_rdl_cadence_OA_TN40CMSP003K3/v2.0_2a/tsmcN45/../models/spectre/toplevel.scs" section=top_tt

// zl_Doherty_Transmitter/3T_noRNW_LVS/schematic
subckt zl_Doherty_Transmitter_3T_noRNW_LVS_schematic DP GP NWP SP
    M0 (DP GP SP SP) nmos_rf lr=40n wr=1u nr=32 multi=3 sa5=1.83619u sa6=1.20015u
ends zl_Doherty_Transmitter_3T_noRNW_LVS_schematic

// zl_Doherty_Transmitter/3CS_noRNW_Cal/schematic
I16 (DN GN VDD GND) zl_Doherty_Transmitter_3T_noRNW_LVS_schematic
I17 (DP GP VDD GND) zl_Doherty_Transmitter_3T_noRNW_LVS_schematic
C3 (D_IND DN VDD) crtmom_wo_rf nv=28 nh=22 w=70n s=70n stm=5 spm=8 multi=1 ftip=140.0n shield=1 dmflag=0
C7 (GP DN VDD) crtmom_wo_rf nv=26 nh=14 w=70n s=70n stm=4 spm=8 multi=1 ftip=140.0n shield=1 dmflag=0
C6 (GN DP VDD) crtmom_wo_rf nv=26 nh=14 w=70n s=70n stm=4 spm=8 multi=1 ftip=140.0n shield=1 dmflag=0
C5 (D_IND DP VDD) crtmom_wo_rf nv=28 nh=22 w=70n s=70n stm=5 spm=8 multi=1 ftip=140.0n shield=1 dmflag=0
simulatorOptions options temp=27
